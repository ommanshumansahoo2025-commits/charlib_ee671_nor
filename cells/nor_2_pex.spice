* NGSPICE file created from nor_gate_1_in_inverted.ext - technology: sky130A

.subckt INVX1 VSS z VDD a
X0 z a VSS VSS sky130_fd_pr__nfet_01v8 ad=0.126 pd=1.44 as=0.126 ps=1.44 w=0.42 l=0.15
**devattr s=5040,288 d=5040,288
X1 z a VDD VDD sky130_fd_pr__pfet_01v8 ad=0.378 pd=3.12 as=0.378 ps=3.12 w=1.26 l=0.15
**devattr s=15120,624 d=15120,624
C0 VDD a 0.08618f
C1 a z 0.03567f
C2 VDD z 0.10833f
C3 z VSS 0.24118f
C4 VDD VSS 0.55073f
.ends

.subckt nor_gate_1_in_inverted A B VDD VSS OUT
XINVX1_0 VSS A_inv VDD A INVX1
X0 a_420_296# B OUT VDD sky130_fd_pr__pfet_01v8 ad=0.411 pd=2.3125 as=0.411 ps=1.97 w=1.37 l=0.15
**devattr s=16440,394 d=16440,394
X1 a_420_296# A_inv VDD VDD sky130_fd_pr__pfet_01v8 ad=0.411 pd=2.3125 as=0.411 ps=2.655 w=1.37 l=0.15
**devattr s=16440,668 d=16440,394
X2 a_420_296# B OUT VDD sky130_fd_pr__pfet_01v8 ad=0.411 pd=2.3125 as=0.411 ps=1.97 w=1.37 l=0.15
**devattr s=16440,394 d=16440,668
X3 a_420_296# A_inv VDD VDD sky130_fd_pr__pfet_01v8 ad=0.411 pd=2.3125 as=0.411 ps=2.655 w=1.37 l=0.15
**devattr s=16440,394 d=16440,394
X4 OUT B a_420_296# VDD sky130_fd_pr__pfet_01v8 ad=0.411 pd=1.97 as=0.411 ps=2.3125 w=1.37 l=0.15
**devattr s=16440,668 d=16440,394
X5 OUT B a_420_296# VDD sky130_fd_pr__pfet_01v8 ad=0.411 pd=1.97 as=0.411 ps=2.3125 w=1.37 l=0.15
**devattr s=16440,394 d=16440,394
X6 VDD A_inv a_420_296# VDD sky130_fd_pr__pfet_01v8 ad=0.411 pd=2.655 as=0.411 ps=2.3125 w=1.37 l=0.15
**devattr s=16440,394 d=16440,394
X7 OUT B VSS VSS sky130_fd_pr__nfet_01v8 ad=0.234 pd=2.16 as=0.234 ps=2.16 w=0.78 l=0.15
**devattr s=9360,432 d=9360,432
X8 OUT A_inv VSS VSS sky130_fd_pr__nfet_01v8 ad=0.234 pd=2.16 as=0.234 ps=2.16 w=0.78 l=0.15
**devattr s=9360,432 d=9360,432
X9 VDD A_inv a_420_296# VDD sky130_fd_pr__pfet_01v8 ad=0.411 pd=2.655 as=0.411 ps=2.3125 w=1.37 l=0.15
**devattr s=16440,394 d=16440,668
C0 A_inv A 0.01732f
C1 a_420_296# A_inv 0.13679f
C2 VDD A_inv 0.4487f
C3 a_420_296# A 0
C4 VDD A 0.04599f
C5 VDD a_420_296# 0.82709f
C6 B OUT 0.16133f
C7 OUT A_inv 0.01363f
C8 OUT A 0
C9 a_420_296# OUT 0.55071f
C10 VDD OUT 0.11227f
C11 B A_inv 0.00796f
C12 a_420_296# B 0.09843f
C13 VDD B 0.23844f
C14 OUT VSS 0.86643f
C15 VDD VSS 2.04599f
C16 a_420_296# VSS 0.68304f
C17 A VSS 0.00529f
.ends
